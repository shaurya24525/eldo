* simulation
* PRE-LAYOUT ELDO SIMULATION
* SS, VDD = 1.08 V, TEMP = 125 C, CLOAD = 20 fF

* Include SS corner file
.include /modelfile_65nm/minNminP.cir

* Include source netlist exported from Cadence
.include nand3.src.net

* Instantiate the NAND3
X1 gnd a b c y vdd nand3

* Parameters
.param SUPPLY = 1.08
.param tend = 120n

* Temperature
.TEMP = 125

* Output load capacitance
C y gnd 20f

* Power supply
vd vdd 0 SUPPLY
vg gnd 0 0

* Input signals
* (time voltage)
v1 a gnd PWL (0 0
+ 40n 0 40.01n 'SUPPLY'
+ 84n 'SUPPLY' 84.01n 0
+ 90n 0 90.01n 'SUPPLY'
+ 120n 'SUPPLY')

v2 b gnd PWL (0 0
+ 20n 0 20.01n 'SUPPLY'
+ 40n 'SUPPLY' 40.01n 0
+ 60n 0 60.01n 'SUPPLY'
+ 96n 'SUPPLY' 96.01n 0
+ 102n 0 102.01n 'SUPPLY'
+ 120n 'SUPPLY')

v3 c gnd PWL (0 0
+ 10n 0 10.01n 'SUPPLY'
+ 20n 'SUPPLY' 20.01n 0
+ 30n 0 30.01n 'SUPPLY'
+ 40n 'SUPPLY' 40.01n 0
+ 50n 0 50.01n 'SUPPLY'
+ 60n 'SUPPLY' 60.01n 0
+ 70n 0 70.01n 'SUPPLY'
+ 108n 'SUPPLY' 108.01n 0
+ 114n 0 114.01n 'SUPPLY'
+ 120n 'SUPPLY')

* Probe voltages and currents
.probe v(*) v(X1.*)
.probe i(*)

************************************************************************
* PROPAGATION DELAY
************************************************************************

* Input A
* Low-to-High propagation delay
.measure tran tplh_a
+ TRIG v(a) VAL='SUPPLY/2' FALL=1 TD=83n
+ TARG v(y) VAL='SUPPLY/2' RISE=1 TD=83n

* High-to-Low propagation delay
.measure tran tphl_a
+ TRIG v(a) VAL='SUPPLY/2' RISE=1 TD=89n
+ TARG v(y) VAL='SUPPLY/2' FALL=1 TD=89n

* Average propagation delay
.measure tpd_a PARAM='(tplh_a+tphl_a)/2'

* Input B
* Low-to-High propagation delay
.measure tran tplh_b
+ TRIG v(b) VAL='SUPPLY/2' FALL=1 TD=95n
+ TARG v(y) VAL='SUPPLY/2' RISE=1 TD=95n

* High-to-Low propagation delay
.measure tran tphl_b
+ TRIG v(b) VAL='SUPPLY/2' RISE=1 TD=101n
+ TARG v(y) VAL='SUPPLY/2' FALL=1 TD=101n

* Average propagation delay
.measure tpd_b PARAM='(tplh_b+tphl_b)/2'

* Input C
* Low-to-High propagation delay
.measure tran tplh_c
+ TRIG v(c) VAL='SUPPLY/2' FALL=1 TD=107n
+ TARG v(y) VAL='SUPPLY/2' RISE=1 TD=107n

* High-to-Low propagation delay
.measure tran tphl_c
+ TRIG v(c) VAL='SUPPLY/2' RISE=1 TD=113n
+ TARG v(y) VAL='SUPPLY/2' FALL=1 TD=113n

* Average propagation delay
.measure tpd_c PARAM='(tplh_c+tphl_c)/2'

************************************************************************
* Powrr
************************************************************************

* Static power
.measure tran Pstatic000 AVG PAR('-SUPPLY*I(VD)') FROM=5n TO=9n
.measure tran Pstatic001 AVG PAR('-SUPPLY*I(VD)') FROM=15n TO=19n
.measure tran Pstatic010 AVG PAR('-SUPPLY*I(VD)') FROM=25n TO=29n
.measure tran Pstatic011 AVG PAR('-SUPPLY*I(VD)') FROM=35n TO=39n
.measure tran Pstatic100 AVG PAR('-SUPPLY*I(VD)') FROM=45n TO=49n
.measure tran Pstatic101 AVG PAR('-SUPPLY*I(VD)') FROM=55n TO=59n
.measure tran Pstatic110 AVG PAR('-SUPPLY*I(VD)') FROM=65n TO=69n
.measure tran Pstatic111 AVG PAR('-SUPPLY*I(VD)') FROM=75n TO=79n

* Dynamic power
.measure tran Pdynamic AVG PAR('-SUPPLY*I(VD)') FROM=84n TO=89n

* Average power
.measure tran Paverage AVG PAR('-SUPPLY*I(VD)') FROM=0n TO=120n

************************************************************************
* TRANSIENT SIMULATION
************************************************************************

.tran 1p tend 0 2p

.end
